* battery voltage divider 100k/100k + 100nF ADC filter
Vbat bat 0 DC 3.7
R6 bat adc 100k
R7 adc 0 100k
C13 adc 0 100n
.control
dc Vbat 3.0 4.2 0.05
wrdata simulation/electronics/.work/batdiv_dc.dat v(adc)
.endc
.end
